// Design: Transistor/PMOS
simulator lang=spectre
global 0
//parameters L=1u M=1 NF=1 VBS=0 VDS=0.5 VGS=0.5 W=1u
include "/home/RodrigoMoraes/Circuit Sizing Tool/files/parametros_p.txt"
include "/home/RodrigoMoraes/1p9m6x1z1u/tsmcN65//../models/spectre/toplevel.scs" section=tt_lib

// Transistor/PMOS/schematic
M0 (net1 net2 0 net3) pch l=L w=W*NF m=M nf=NF
V2 (0 net2) vsource dc=VGS type=dc
V1 (0 net3) vsource dc=VBS type=dc
V0 (0 net1) vsource dc=VDS type=dc
simulatorOptions options temp=27
dcOp dc
