// Design: teste/pmos
simulator lang=spectre
global 0
//parameters L=180n W=0.0001786650292272758 NF=1 M=1 VBS=0.6 VGS=0.6 VDS=1
include "/home/RodrigoMoraes/Circuit Sizing Tool/files/parametros_p.txt"
include "/tools/pdk/tsmc/tsmc180/tsmc18//../models/spectre/cr018gpii_v1d0.scs" section=tt_rfres_sa
include "/tools/pdk/tsmc/tsmc180/tsmc18//../models/spectre/cr018gpii_v1d0.scs" section=tt_rfmvar
include "/tools/pdk/tsmc/tsmc180/tsmc18//../models/spectre/cr018gpii_v1d0.scs" section=tt_rtmom
include "/tools/pdk/tsmc/tsmc180/tsmc18//../models/spectre/cr018gpii_v1d0.scs" section=tt_disres
include "/tools/pdk/tsmc/tsmc180/tsmc18//../models/spectre/cr018gpii_v1d0.scs" section=tt
include "/tools/pdk/tsmc/tsmc180/tsmc18//../models/spectre/cr018gpii_v1d0.scs" section=tt_rfesd
include "/tools/pdk/tsmc/tsmc180/tsmc18//../models/spectre/cr018gpii_v1d0.scs" section=tt_mim
include "/tools/pdk/tsmc/tsmc180/tsmc18//../models/spectre/cr018gpii_v1d0.scs" section=tt_fmom
include "/tools/pdk/tsmc/tsmc180/tsmc18//../models/spectre/cr018gpii_v1d0.scs" section=tt_rfres_rpo
include "/tools/pdk/tsmc/tsmc180/tsmc18//../models/spectre/cr018gpii_v1d0.scs" section=tt_m
include "/tools/pdk/tsmc/tsmc180/tsmc18//../models/spectre/cr018gpii_v1d0.scs" section=tt_rfmim
include "/tools/pdk/tsmc/tsmc180/tsmc18//../models/spectre/cr018gpii_v1d0.scs" section=tt_res
include "/tools/pdk/tsmc/tsmc180/tsmc18//../models/spectre/cr018gpii_v1d0.scs" section=tt_bip
include "/tools/pdk/tsmc/tsmc180/tsmc18//../models/spectre/cr018gpii_v1d0.scs" section=tt_bip3
include "/tools/pdk/tsmc/tsmc180/tsmc18//../models/spectre/cr018gpii_v1d0.scs" section=tt_dio3
include "/tools/pdk/tsmc/tsmc180/tsmc18//../models/spectre/cr018gpii_v1d0.scs" section=tt_3v
include "/tools/pdk/tsmc/tsmc180/tsmc18//../models/spectre/cr018gpii_v1d0.scs" section=tt_na
include "/tools/pdk/tsmc/tsmc180/tsmc18//../models/spectre/cr018gpii_v1d0.scs" section=tt_dio
include "/tools/pdk/tsmc/tsmc180/tsmc18//../models/spectre/cr018gpii_v1d0.scs" section=tt_dio_m
include "/tools/pdk/tsmc/tsmc180/tsmc18//../models/spectre/cr018gpii_v1d0.scs" section=tt_rfind
include "/tools/pdk/tsmc/tsmc180/tsmc18//../models/spectre/cr018gpii_v1d0.scs" section=tt_dio_3m
include "/tools/pdk/tsmc/tsmc180/tsmc18//../models/spectre/cr018gpii_v1d0.scs" section=tt_bbmvar
include "/tools/pdk/tsmc/tsmc180/tsmc18//../models/spectre/cr018gpii_v1d0.scs" section=tt_rfres_hri
include "/tools/pdk/tsmc/tsmc180/tsmc18//../models/spectre/cr018gpii_v1d0.scs" section=tt_3vna
include "/tools/pdk/tsmc/tsmc180/tsmc18//../models/spectre/cr018gpii_v1d0.scs" section=tt_dio_dnw
include "/tools/pdk/tsmc/tsmc180/tsmc18//../models/spectre/cr018gpii_v1d0.scs" section=tt_3m
include "/tools/pdk/tsmc/tsmc180/tsmc18//../models/spectre/cr018gpii_v1d0.scs" section=tt_rfjvar
include "/tools/pdk/tsmc/tsmc180/tsmc18//../models/spectre/cr018gpii_v1d0.scs" section=tt_rfmos
include "/tools/pdk/tsmc/tsmc180/tsmc18//../models/spectre/cr018gpii_v1d0.scs" section=tt_rfsbd
include "/tools/pdk/tsmc/tsmc180/tsmc18//../models/spectre/cr018gpii_v1d0.scs" section=tt_rfmvar_33
include "/tools/pdk/tsmc/tsmc180/tsmc18//../models/spectre/cr018gpii_v1d0.scs" section=tt_rfmos33
include "/tools/pdk/tsmc/tsmc180/tsmc18//../models/spectre/cr018gpii_v1d0.scs" section=tt_rffmom
include "/tools/pdk/tsmc/tsmc180/tsmc18//../models/spectre/cr018gpii_v1d0.scs" section=stat_noise

// teste/pmos/schematic
M0 (net04 net3 0 net5) mepch l=L w=W*NF m=M nf=NF
VDS (0 net04) vsource dc=VDS type=dc
VGS (0 net3) vsource dc=VGS type=dc
VBS (0 net5) vsource dc=VBS type=dc
simulatorOptions options temp=27
dcOp dc
